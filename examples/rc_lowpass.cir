* RC low-pass example for the Python LTspice wrapper
V1 in 0 AC 1
R1 in out 10k
C1 out 0 1u
.ac dec 100 10 1Meg
.meas ac gain_at_1k FIND mag(V(out)) AT=1k
.end
