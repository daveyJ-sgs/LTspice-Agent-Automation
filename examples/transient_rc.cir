* RC low-pass transient example for automated waveform checks
V1 in 0 PULSE(0 5 0 1n 1n 5m 10m)
R1 in out 1k
C1 out 0 1u
.tran 0 50m 0 10u
.meas tran vout_max MAX V(out) FROM=0 TO=50m
.meas tran vout_min MIN V(out) FROM=0 TO=50m
.end
